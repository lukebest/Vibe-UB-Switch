// Vibe-UB-Switch management command map (rtl/mgmt, this commit).
//
// This file is NOT MMIO and does not describe APB/AXI/I2C/JTAG.
// There is no address decode in rtl/mgmt. Firmware "address" is cfg_wr_cmd[3:0].
// Handshake (top vibe_ub_switch): cfg_wr_vld, cfg_wr_ready (tied 1),
// cfg_wr_cmd[3:0], cfg_wr_idx[15:0], cfg_wr_data[31:0], pin irq_logic.
//
// AS-0.1.2: cfg_wr_cmd is 4 bits. Opcodes 0-5; 6-15 ignore (still pulse irq_clr).
// No product cfg_rd_* pin (AS §18). Port Reset is RW1C per port (Table D-103).
// CFG6 opcode 0x10 payload packing / Appendix D offsets: 未知 — cna_ep echos.
//
// Source: vibe_cfg_space.sv, vibe_cna_ep.sv, vibe_irq_agg.sv, vibe_mgmt.sv,
//         vibe_rst_ctl.sv, vibe_ub_params.vh, vibe_ub_switch ports, AS-0.1.2.

property vibe_fw_cmd {
    type = longint unsigned;
    component = reg;
    desc = "not MMIO; firmware address = cfg_wr_cmd encoding";
};

property vibe_payload {
    type = string;
    component = field;
    desc = "not MMIO; which static-write pin the field is driven on";
};

property vibe_identity_guid0 {
    type = longint unsigned;
    component = addrmap;
    desc = "not MMIO; compile-time identity; not readable this RTL";
};

property vibe_identity_class_code {
    type = longint unsigned;
    component = addrmap;
    desc = "not MMIO; compile-time identity; not readable this RTL";
};

property vibe_identity_port_basic {
    type = longint unsigned;
    component = addrmap;
    desc = "not MMIO; compile-time identity; not readable this RTL";
};

property vibe_identity_port_cap {
    type = longint unsigned;
    component = addrmap;
    desc = "not MMIO; compile-time identity; not readable this RTL";
};

addrmap vibe_ub_switch_mgmt {
    name = "vibe_ub_switch_mgmt";
    desc = "Static-write handshake command map. not MMIO.
            Address column is cfg_wr_cmd[3:0] (0..5), not a hex bus offset.
            Every accepted cfg_wr (including ignored cmd 6-15) pulses irq_clr.
            cfg_wr_ready is tied 1. Route table RAM is in fabric, not mgmt.";

    addressing = compact;
    alignment = 1;

    // Compile-time combo constants in vibe_cfg_space; tied off in vibe_mgmt.
    // Not on chip pins. Not readable via cfg_wr. CFG6 path echos the request.
    vibe_identity_guid0 = 32'h00000003;
    vibe_identity_class_code = 32'h00000300;
    vibe_identity_port_basic = 32'h00040402;
    vibe_identity_port_cap = 32'h00000104;

    // Handshake and IRQ are pins, not registers. not MMIO.
    signal { signalwidth = 1; desc = "not MMIO; write strobe"; } cfg_wr_vld;
    signal { signalwidth = 1; desc = "not MMIO; tied 1 in vibe_cfg_space"; } cfg_wr_ready;
    signal { signalwidth = 4; desc = "not MMIO; command encoding (firmware address)"; } cfg_wr_cmd;
    signal { signalwidth = 16; desc = "not MMIO; index / port select"; } cfg_wr_idx;
    signal { signalwidth = 32; desc = "not MMIO; write data"; } cfg_wr_data;
    signal {
        signalwidth = 1;
        desc = "not MMIO; top pin irq_logic. Firmware reads the pin only.
                1-bit sticky OR of error inputs. No per-cause status register.
                Clear: any accepted cfg_wr, rst_n, or device_rst.
                Port Reset hold (port_rst) does not clear irq.
                Product IRQ pin name / polarity / vector count: 未知.";
    } irq_logic;

    // ---------------------------------------------------------------------
    // cmd 0 — CMD_CNA
    // ---------------------------------------------------------------------
    reg {
        name = "CMD_CNA";
        desc = "not MMIO; cfg_wr_cmd=0. Write CNA[15:0] and set cna_written.
                Side effect: irq_clr pulse.";
        vibe_fw_cmd = 0;

        field {
            sw = w;
            hw = r;
            reset = 16'h0;
            vibe_payload = "cfg_wr_data";
            desc = "not MMIO. width=16. access=WO. reset=16'h0 in RTL flops.
                    Product CNA power-on default is 未知; do not treat 0 as a
                    valid CNA. DCNA match is gated by internal cna_written
                    (reset 0, set on this write). cfg_wr_data[31:16] unused.";
        } CNA[15:0];
    } CMD_CNA @0x0;

    // ---------------------------------------------------------------------
    // cmd 1 — CMD_ROUTE_TABLE
    // ---------------------------------------------------------------------
    reg {
        name = "CMD_ROUTE_TABLE";
        desc = "not MMIO; cfg_wr_cmd=1. Pulse a route-table write into fabric.
                cfg_wr_idx[15:0] is captured in full; fabric RAM indexes [7:0]
                (DEPTH=256 architecture default, not product Max Index).
                RAM lives in fabric, not mgmt. Side effect: irq_clr pulse.";
        vibe_fw_cmd = 1;

        field {
            sw = w;
            hw = r;
            reset = 4'h0;
            vibe_payload = "cfg_wr_data";
            desc = "not MMIO. width=4. access=WO. reset=4'h0 (RAM cleared on
                    rst_n / device_rst in fabric). Egress bitmap in
                    cfg_wr_data[3:0]; [31:4] are captured then unused by lookup.
                    AS-0.1.2: only [3:0] meaningful. cfg_wr_idx[15:0] (RT_IDX)
                    is captured in full; fabric RAM uses [7:0]. Max Index: 未知.";
        } RT_BM[3:0];
    } CMD_ROUTE_TABLE @0x1;

    // ---------------------------------------------------------------------
    // cmd 2 — CMD_DEFAULT_BM
    // ---------------------------------------------------------------------
    reg {
        name = "CMD_DEFAULT_BM";
        desc = "not MMIO; cfg_wr_cmd=2. Write default egress bitmap.
                Side effect: irq_clr pulse.";
        vibe_fw_cmd = 2;

        field {
            sw = w;
            hw = r;
            reset = 4'h0;
            vibe_payload = "cfg_wr_data";
            desc = "not MMIO. width=4. access=WO. reset=4'h0.
                    cfg_wr_data[3:0]; [31:4] unused.";
        } default_bm[3:0];
    } CMD_DEFAULT_BM @0x2;

    // ---------------------------------------------------------------------
    // cmd 3 — CMD_PORT_RST (Table D-103 Port Reset, RW1C per port)
    // ---------------------------------------------------------------------
    reg {
        name = "CMD_PORT_RST";
        desc = "not MMIO; cfg_wr_cmd=3. Port Reset RW1C for port
                cfg_wr_idx[1:0]. Table D-103: bit 0 RW1C_DE0_EO,
                1=reset, 0=normal. Write data[0]=1 applies that port's
                sequence and holds the stored bit at 1 until rst_ctl
                hold ends (HW returns 0). data[0]=0 does not start reset.
                port_rst hold does not clear irq; the static write still
                pulses irq_clr. CFG6 payload packing: 未知.";
        vibe_fw_cmd = 3;

        field {
            sw = w;
            hw = r;
            reset = 2'h0;
            vibe_payload = "cfg_wr_idx";
            desc = "not MMIO. width=2. Selects port 0..3. Not a status bit.
                    cfg_wr_idx[1:0] = port.";
        } PORT[1:0];

        field {
            sw = rw;
            hw = rw;
            onwrite = woclr;
            reset = 1'b0;
            vibe_payload = "cfg_wr_data";
            desc = "not MMIO. width=1. access=RW1C. reset=1'b0 (normal).
                    cfg_wr_data[0]. Write 1 starts Port Reset and sets the
                    mgmt flop (readable 1=reset) until rst_ctl hold ends.
                    Write 0 has no reset side effect. RSVD [31:1] RO.
                    No top-level read pin. CFG6 packing: 未知.";
        } Port_Reset[0:0];
    } CMD_PORT_RST @0x3;

    // ---------------------------------------------------------------------
    // cmd 4 — CMD_DEVICE_RST
    // ---------------------------------------------------------------------
    reg {
        name = "CMD_DEVICE_RST";
        desc = "not MMIO; cfg_wr_cmd=4. WO pulse device reset. idx and data
                unused. NOT an RW1C readable bit. device_rst also clears irq
                in vibe_mgmt (irq_clr | device_rst). The write pulses irq_clr.
                Clears RW config to unwritten (CNA unwritten) in cfg_space.
                MUST NOT by itself force DLL_Disabled.";
        vibe_fw_cmd = 4;

        field {
            sw = w;
            hw = w;
            reset = 1'b0;
            vibe_payload = "unused";
            desc = "not MMIO. width=1. access=WO pulse. reset=n/a (not a
                    stored bit). Payload unused; the accepted write is the pulse.";
        } DEVICE_RST[0:0];
    } CMD_DEVICE_RST @0x4;

    // ---------------------------------------------------------------------
    // cmd 5 — CMD_LMSM_GO
    // ---------------------------------------------------------------------
    reg {
        name = "CMD_LMSM_GO";
        desc = "not MMIO; cfg_wr_cmd=5. WO pulse lmsm_go for port
                cfg_wr_idx[1:0]. NOT an RW1C readable bit.
                Side effect: irq_clr pulse + lmsm_go_pulse.";
        vibe_fw_cmd = 5;

        field {
            sw = w;
            hw = w;
            reset = 2'h0;
            vibe_payload = "cfg_wr_idx";
            desc = "not MMIO. width=2. access=WO pulse. reset=n/a (index, not
                    a stored bit). cfg_wr_idx[1:0] = port 0..3.
                    cfg_wr_data unused.";
        } PORT[1:0];
    } CMD_LMSM_GO @0x5;

    // cmd 6-15: ignored encodings (4-bit). No fields. Still pulse irq_clr.
    //
    // Identity constants (not registers, not a cfg_wr_cmd, not MMIO):
    //   guid0      = 32'h00000003  access=not readable this RTL
    //   class_code = 32'h00000300  access=not readable this RTL
    //   PORT_BASIC = 32'h00040402  access=not readable this RTL  bit packing 未知
    //   PORT_CAP   = 32'h00000104  access=not readable this RTL  bit packing 未知
    // Tied off in vibe_mgmt. CFG6 path echos the request.
};
